ADE simulation setup
Run mode: Single Run, Sweeps and Corners
Tests:
  tran: MyOpAmp/OpAmp_tran/schematic, simulator spectre
    Variables: CL = 1p; ibias = 10u; vdc = 1; vdd = 2; vss = 0
    Outputs: Pdiss; Offset; Slew Rate
  ac: MyOpAmp/OpAmp_ac/schematic, simulator spectre
    Variables: CL = 1p; ibias = 10u; vdc = 1; vdd = 2; vss = 0; vac = 100m
    Outputs: UGB; Av0
Global variables:
  ibias = 10.5u
Device parameters:
  MyOpAmp/OpAmp/schematic/M0.l = 750n
  MyOpAmp/OpAmp/schematic/M1.l = M0/l@MyOpAmp/OpAmp/schematic
  MyOpAmp/OpAmp/schematic/M3.l = M0/l@MyOpAmp/OpAmp/schematic
  MyOpAmp/OpAmp/schematic/M3.w = 1.5u
  MyOpAmp/OpAmp/schematic/M4.l = M0/l@MyOpAmp/OpAmp/schematic
  MyOpAmp/OpAmp/schematic/M4.w = M3/w@MyOpAmp/OpAmp/schematic
  MyOpAmp/OpAmp/schematic/M6.l = M0/l@MyOpAmp/OpAmp/schematic
  MyOpAmp/OpAmp/schematic/M7.l = M0/l@MyOpAmp/OpAmp/schematic
Specs:
  tran / Slew Rate: > 50M
  tran / Settling Time: < 50n
  tran / Pdiss: < 200u
  tran / Offset: range -10m to 10m
  ac / UGB: > 50M
  ac / Av0: > 60
