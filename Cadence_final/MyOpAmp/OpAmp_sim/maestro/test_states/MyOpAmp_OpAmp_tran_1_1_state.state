ADE simulation setup
Test MyOpAmp_OpAmp_tran_1_1: MyOpAmp/OpAmp_tran/schematic, simulator spectre
  Models: /servers/esd_noida/steja/Basic_Analog_Flow/final/CAICDF/GPDK045/gpdk045/../models/spectre/gpdk045.scs[tt]
  Variables: CL = 1p; ibias = 10u; vdc = 1; vdd = 2; vss = 0
  Temperature: 27
  Analysis dc: (saves the operating point)
  Analysis tran: stop=100u
  Output Vout_tran = VT("/OUT")
  Output Vin_tran = VT("/IN")
  Output Vout_dc = VDC("/OUT")
  Output Vin_dc = VDC("/IN")
  Signals: /OUT, /IN
