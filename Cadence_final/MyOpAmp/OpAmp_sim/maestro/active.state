ADE simulation setup
Test tran: MyOpAmp/OpAmp_tran/schematic, simulator spectre
  Models: /servers/esd_noida/steja/Basic_Analog_Flow/final/CAICDF/GPDK045/gpdk045/../models/spectre/gpdk045.scs[tt]
  Variables: CL = 1p; ibias = 10u; vdc = 1; vdd = 2; vss = 0
  Temperature: 27
  Analysis dc: (saves the operating point)
  Analysis tran: stop=100u
  Output Vout_tran = VT("/OUT")
  Output Vin_tran = VT("/IN")
  Output Vout_dc = VDC("/OUT")
  Output Vin_dc = VDC("/IN")
  Output Slew Rate = abs(slewRate(Vout_tran 1.3 nil 0.7 nil 20 80 nil "time"))
  Output Settling Time = settlingTime(Vout_tran 0 t 2e-06 t 1 nil "time")
  Output Pdiss = abs((2 * IDC("/VDD_source/PLUS")))
  Output Offset = (Vout_dc - Vin_dc)
  Signals: /OUT, /IN, /VDD_source/PLUS (terminal)
Test ac: MyOpAmp/OpAmp_ac/schematic, simulator spectre
  Models: /servers/esd_noida/steja/Basic_Analog_Flow/final/CAICDF/GPDK045/gpdk045/../models/spectre/gpdk045.scs[tt]
  Variables: vac = 100m; CL = 1p; ibias = 10u; vdc = 1; vdd = 2; vss = 0
  Temperature: 27
  Analysis ac: start=1 stop=1G dec=10
  Output Av_ac = dB20((VF("/OUT") / VF("/IN")))
  Output UGB = cross(Av_ac 0 1 "falling" nil nil nil)
  Output Av0 = value(Av_ac 0 ?scale '(roundDown))
  Signals: /OUT, /IN
Run mode: Single Run, Sweeps and Corners
Global variables:
  ibias = 10.5u
Device parameters:
  MyOpAmp/OpAmp/schematic/M0.l = 750n
  MyOpAmp/OpAmp/schematic/M1.l = M0/l@MyOpAmp/OpAmp/schematic
  MyOpAmp/OpAmp/schematic/M3.l = M0/l@MyOpAmp/OpAmp/schematic
  MyOpAmp/OpAmp/schematic/M3.w = 1.5u
  MyOpAmp/OpAmp/schematic/M4.l = M0/l@MyOpAmp/OpAmp/schematic
  MyOpAmp/OpAmp/schematic/M4.w = M3/w@MyOpAmp/OpAmp/schematic
  MyOpAmp/OpAmp/schematic/M6.l = M0/l@MyOpAmp/OpAmp/schematic
  MyOpAmp/OpAmp/schematic/M7.l = M0/l@MyOpAmp/OpAmp/schematic
Specs:
  tran / Slew Rate: > 50M
  tran / Settling Time: < 50n
  tran / Pdiss: < 200u
  tran / Offset: range -10m to 10m
  ac / UGB: > 50M
  ac / Av0: > 60
